# Ansys Electronics Desktop project, version 2023.2
materials:
  air: permittivity=1.0006 permeability=1.0000004
  copper: permeability=1 conductivity=58000000
  FR4_epoxy: permittivity=4.4 dielectric_loss_tangent=0.02
  pec: permeability=1 conductivity=1e+30
  R-5670G: permittivity=3.4 dielectric_loss_tangent=0.002
  R-5775G_1035: permittivity=3.46 dielectric_loss_tangent=0.002
  R-5775G_2116: permittivity=3.71 dielectric_loss_tangent=0.002
  solder: permeability=1 conductivity=7000000
  SolderMask: permittivity=4.6 dielectric_loss_tangent=0.035
  vacuum: permittivity=1

design relaxed_transition (HFSS 3D Layout)
ports:
  Port1..Port4: Properties{Reference=GNDs:GND:poly_7 Impedance=50ohm Magnitude=1V Phase=0deg Renormalize_Impedence="50ohm + 0i ohm" Renormalize Deembed_Distance=0mm Deembed Type="Single Strip Gap Source" HFSS_Type=Gap Orientation=Vertical Layer_Alignment=Upper Horizontal_Extent_Factor=5 Vertical_Extent_Factor=3 PEC_Launch_Width=0.01mm Reference_Net=GND} Type=EdgePort
setups:
  Setup1: SolveSetupType=HFSS PercentRefinementPerPass=30 MinNumberOfPasses=1 MinNumberOfConvergedPasses=1 Frequency=10GHz MeshSizeFactor=1.5 ViaNumSides=6 Style25DVia=Mesh
    sweep Sweep: LINC 10MHz 5GHz 100; SAbsError=0.005 ZoPercentError=1 PassivityTolerance=0.0001 MaxSolutions=250 InterpUseSMatrix InterpUsePortImpedance InterpUseFullBasis MinSolvedFreq=0.01GHz AutoSMatOnlySolve MinFreqSMatrixOnlySolve=1MHz MagMinThreshold=0.01 InterpMinSolutions=0 FreqSweepType=kDiscrete
reports:
  S Parameter Plot 1: dB(S(Diff1,Diff1)), dB(S(Diff2,Diff2)) vs Freq on Setup1 : Sweep
