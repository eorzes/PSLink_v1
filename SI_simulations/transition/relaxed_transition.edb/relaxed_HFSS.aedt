# Ansys Electronics Desktop project, version 2023.2
materials:
  air: permittivity=1.0006 permeability=1.0000004
  vacuum: permittivity=1
  pec: permeability=1 conductivity=1e+30
  copper: permeability=1 conductivity=58000000
  FR4_epoxy: permittivity=4.4 dielectric_loss_tangent=0.02
  R-5670G: permittivity=3.4 dielectric_loss_tangent=0.002
  R-5775G_1035: permittivity=3.46 dielectric_loss_tangent=0.002
  R-5775G_2116: permittivity=3.71 dielectric_loss_tangent=0.002
  SolderMask: permittivity=4.6 dielectric_loss_tangent=0.035

design HFSSDesign1 (HFSS, HFSS Terminal Network, model units mm)
options: Allow_Material_Override Calculate_Lossy_Dielectrics Save_Adaptive_support_files
geometry:
  Core_Top [R-5775G_1035] = imported_body()
  GNDs [copper] = imported_body()
  Port_Port1..Port_Port4 [pec] = imported_body()
  Top_Layer, Top_Layer_L1..Top_Layer_L4 [copper] = imported_body()
  Top_Layer_t_fill [SolderMask] = imported_body()
  airbox [air] = imported_body()
  smask [SolderMask] = imported_body()
boundaries and excitations:
  airbox_RAD: Radiation Objects=airbox
  reference conductors: GNDs, Top_Layer_L2
mesh:
  initial mesh: MeshMethod=AnsoftClassic
setups:
  Setup1: HfssDriven Frequency=5GHz MaxDeltaE=0.1 MaximumPasses=20 MinimumPasses=1 MinimumConvergedPasses=1 PercentRefinement=30 BasisOrder=-1 DrivenSolverType="Direct Solver"
    sweep Sweep: 10MHz to 5GHz, 30 points; Type=Discrete
reports:
  Terminal S Parameter Plot 1: dB(St(Diff1,Diff1)) vs Freq on Setup1 : Sweep
  Terminal S Parameter Plot 2: dB(St(Diff2,Diff2)), dB(St(Diff1,Diff1)) vs Freq on Setup1 : Sweep
  Solution Convergence Plot 1: SolvedElements vs Pass on Setup1 : AdaptivePass [Freq=all]
  Solution Convergence Plot 2: MaxMagDeltaS vs Pass on Setup1 : AdaptivePass [Freq=all]
